procedure(pRequire(x) unless(x error("C1_PDEFAULT_ASSERT")) x)
procedure(pNames() list("w" "fw" "as" "ad" "ps" "pd"))
procedure(pOld() "CmosLong20261111")
procedure(pNew() "__PMOS_CHILD_LIBRARY__")
procedure(pOpen(lib cell view mode)
 let((cv)
  cv=dbOpenCellViewByType(lib cell view "" mode)
  pRequire(and(cv cv~>libName==lib cv~>cellName==cell cv~>viewName==view))
  cv))
procedure(pClose(cv) pRequire(dbClose(cv)))
procedure(pInstance(cv name lib cell count)
 let((matches inst)
  matches=setof(item cv~>instances item~>name==name)
  pRequire(length(matches)==1)
  inst=car(matches)
  pRequire(and(inst~>libName==lib inst~>cellName==cell inst~>viewName=="symbol"
               length(inst~>instTerms)==count inst~>orient=="R0"))
  inst))
procedure(pNameLess(left right) alphalessp(car(left) car(right)))
procedure(pProperties(inst omit)
 let((rows)
  pRequire(length(inst~>prop)<=80)
  foreach(prop inst~>prop
   unless(member(prop~>name omit)
    rows=cons(list(prop~>name prop~>valueType prop~>value) rows)))
  sort(rows 'pNameLess)))
procedure(pLinks(terms)
 sort(foreach(mapcar term terms list(term~>name if(term~>net then term~>net~>name else nil))) 'pNameLess))
procedure(pPorts(cv)
 sort(foreach(mapcar term cv~>terminals
       list(term~>name term~>direction if(term~>net then term~>net~>name else nil))) 'pNameLess))
procedure(pSignature(cv omitSelected retarget)
 let((rows lib)
  pRequire(and(length(cv~>instances)<=8 length(cv~>terminals)<=8 length(cv~>nets)<=32))
  foreach(inst cv~>instances
   lib=if(retarget && inst~>name=="DUT" then pNew() else inst~>libName)
   rows=cons(list(inst~>name lib inst~>cellName inst~>viewName inst~>orient inst~>xy
                  pLinks(inst~>instTerms)
                  pProperties(inst if(omitSelected && inst~>name=="MP" then pNames() else nil))) rows))
  list(sort(rows 'pNameLess) pPorts(cv) sort(foreach(mapcar net cv~>nets net~>name) 'alphalessp))))
procedure(pTopology(cv tbLib)
 if(tbLib then
  pRequire(length(cv~>instances)==4)
  pInstance(cv "DUT" tbLib "InvLong" 4)
  pInstance(cv "VDD" "analogLib" "vdc" 2)
  pInstance(cv "VIN" "analogLib" "vpulse" 2)
  pInstance(cv "CL" "analogLib" "cap" 2)
 else
  pRequire(length(cv~>terminals)==4)
  pInstance(cv "MN" "gpdk090" "nmos1v" 4)
  pInstance(cv "MP" "gpdk090" "pmos1v" 4))
 t)
procedure(pTable()
 list(list("w" "lengthMetric" "350n" "120n") list("fw" "lengthMetric" "350n" "120n")
      list("l" "lengthMetric" "100n" "100n") list("m" "nil" "1" "1")
      list("fingers" "nil" "1" "1") list("model" "nil" "gpdk090_pmos1v" "gpdk090_pmos1v")
      list("as" "nil" "98f" "69.6f") list("ad" "nil" "98f" "69.6f")
      list("ps" "lengthMetric" "1.26u" "1.16u") list("pd" "lengthMetric" "1.26u" "1.16u")))
procedure(pTuple(port cv stage)
 let((mp cdf param prop kind val units row expected defValue isBase before omit ok)
  isBase=stage=="BASE"
  before=stage=="COPY_BASELINE"
  mp=pInstance(cv "MP" "gpdk090" "pmos1v" 4)
  cdf=if(isBase then cdfGetBaseCellCDF(ddGetObj("gpdk090" "pmos1v")) else cdfGetInstCDF(mp))
  ok=t
  foreach(row pTable()
   param=cdf && cdfFindParamByName(cdf car(row))
   expected=if(before then caddr(row) else cadddr(row))
   val=if(param && stringp(param~>value) then param~>value else "-")
   units=if(param && stringp(param~>units) then param~>units else "nil")
   kind=if(param && stringp(param~>type) then param~>type else "-")
   fprintf(port "CDF|%s|%s|%s|%s|%s\n" stage car(row) kind units val)
   unless(and(kind==if(isBase then "baseCellData" else "instData")
              units==cadr(row) val==expected)
    ok=nil)
   when(before && member(car(row) pNames())
    defValue=if(param && stringp(param~>defValue) then param~>defValue else "-")
    fprintf(port "DEFAULT|COPY_BASELINE|%s|%s\n" car(row) defValue)
    unless(defValue==cadddr(row) ok=nil))
   unless(isBase
    omit=(!before && member(car(row) pNames()))
    prop=dbFindProp(mp car(row))
    if(prop then
     val=if(stringp(prop~>value) then prop~>value else "-")
     kind=if(stringp(prop~>valueType) then prop~>valueType else "-")
     fprintf(port "OA|%s|%s|EXPLICIT|%s|%s\n" stage car(row) kind val)
     unless(and(!omit kind=="string" val==expected) ok=nil)
    else
     fprintf(port "OA|%s|%s|ABSENT|-|-\n" stage car(row))
     unless(omit ok=nil)))
  )
  pRequire(ok)))
procedure(pCopy(cv)
 let((child)
  pRequire(!ddGetObj(pNew() cv~>cellName cv~>viewName))
  child=dbCopyCellView(cv pNew() cv~>cellName cv~>viewName nil nil nil)
  pRequire(and(child child~>libName==pNew() child~>cellName==cv~>cellName child~>viewName==cv~>viewName))
  pRequire(dbSave(child))
  pClose(child)))
procedure(pOwnedReversion(port)
 let((srcDut srcSym srcTb dstSym dstTb dstDut expectedDut expectedTb expectedTbChild
       stableDut tbInst mp)
  foreach(api '(dbCopyCellView dbDeletePropByName schCheck cdfGetInstCDF cdfFindParamByName)
   pRequire(isCallable(api)))
  pRequire(!ddGetObj(pNew()))
  srcDut=pOpen(pOld() "InvLong" "schematic" "r")
  srcSym=pOpen(pOld() "InvLong" "symbol" "r")
  srcTb=pOpen(pOld() "InvLongTb" "schematic" "r")
  pTopology(srcDut nil)
  pTopology(srcTb pOld())
  expectedDut=pSignature(srcDut nil nil)
  stableDut=pSignature(srcDut t nil)
  expectedTb=pSignature(srcTb nil nil)
  expectedTbChild=pSignature(srcTb nil t)
  pRequire(ddCreateLib(pNew() "__PMOS_JOB__/__PMOS_CHILD_LIBRARY__"))
  pCopy(srcDut) pCopy(srcSym) pCopy(srcTb)
  dstSym=pOpen(pNew() "InvLong" "symbol" "r")
  pRequire(and(equal(pSignature(dstSym nil nil) pSignature(srcSym nil nil))
               equal(dstSym~>bBox srcSym~>bBox)))
  dstTb=pOpen(pNew() "InvLongTb" "schematic" "a")
  pRequire(equal(pSignature(dstTb nil nil) expectedTb))
  tbInst=pInstance(dstTb "DUT" pOld() "InvLong" 4)
  tbInst~>master=dstSym
  pRequire(schCheck(dstTb))
  pTopology(dstTb pNew())
  pRequire(equal(pSignature(dstTb nil nil) expectedTbChild))
  pRequire(dbSave(dstTb))
  pClose(dstTb)
  dstTb=pOpen(pNew() "InvLongTb" "schematic" "r")
  pTopology(dstTb pNew())
  pRequire(equal(pSignature(dstTb nil nil) expectedTbChild))
  pClose(dstTb)
  fprintf(port "TB|REOPENED|__PMOS_CHILD_LIBRARY__|InvLong|symbol\n")
  dstDut=pOpen(pNew() "InvLong" "schematic" "a")
  pTopology(dstDut nil)
  pRequire(equal(pSignature(dstDut nil nil) expectedDut))
  fprintf(port "COPY|SOURCE_AND_CHILD|TOPOLOGY_AND_PROPERTIES_EQUAL\n")
  pTuple(port dstDut "BASE")
  pTuple(port dstDut "COPY_BASELINE")
  mp=pInstance(dstDut "MP" "gpdk090" "pmos1v" 4)
  foreach(name pNames()
   pRequire(dbFindProp(mp name))
   dbDeletePropByName(mp name)
   pRequire(!dbFindProp(mp name)))
  pRequire(schCheck(dstDut))
  pRequire(equal(pSignature(dstDut t nil) stableDut))
  pTuple(port dstDut "BEFORE_SAVE")
  pRequire(dbSave(dstDut))
  pClose(dstDut)
  dstDut=pOpen(pNew() "InvLong" "schematic" "r")
  pTopology(dstDut nil)
  pRequire(equal(pSignature(dstDut t nil) stableDut))
  pTuple(port dstDut "REOPENED")
  pClose(dstDut) pClose(dstSym) pClose(srcTb) pClose(srcSym) pClose(srcDut)
  fprintf(port "COPY|REOPENED|FIXED_TOPOLOGY_AND_PROPERTIES_EQUAL\n")
  t))
let((port result)
 port=outfile("__PMOS_JOB__/revert.frame")
 unless(port exit(1))
 fprintf(port "C1_PMOS_OVERRIDE_REVERSION|1\n")
 result=errset(pOwnedReversion(port) nil)
 when(result fprintf(port "COMPLETE\n"))
 close(port)
 if(result then exit(0) else exit(1)))
