procedure(ampRequire(ok) unless(ok error("C1_AMP_COPY_REJECTED")) ok)
procedure(ampOpen(lib)
  let((cv)
    cv=dbOpenCellViewByType(lib "Differential_Amplifier_TB2" "schematic" "" "r")
    ampRequire(and(cv cv~>libName==lib cv~>cellName=="Differential_Amplifier_TB2"
                   cv~>viewName=="schematic")) cv))
procedure(ampLess(left right) alphalessp(car(left) car(right)))
procedure(ampLinks(terms)
  sort(foreach(mapcar term terms
    list(term~>name if(term~>net then term~>net~>name else nil))) 'ampLess))
procedure(ampProperties(inst omitWidth)
  ampRequire(length(inst~>prop)<=128)
  sort(foreach(mapcar prop setof(p inst~>prop !(omitWidth && inst~>name=="PM0" && member(p~>name list("w" "fw" "as" "ad" "ps" "pd"))))
    list(prop~>name prop~>valueType prop~>value)) 'ampLess))
procedure(ampSignature(cv omitWidth)
  ampRequire(and(length(cv~>instances)<=128 length(cv~>terminals)<=128 length(cv~>nets)<=512))
  list(sort(foreach(mapcar inst cv~>instances
    list(inst~>name inst~>libName inst~>cellName inst~>viewName inst~>orient inst~>xy
         ampLinks(inst~>instTerms) ampProperties(inst omitWidth))) 'ampLess)
    sort(foreach(mapcar term cv~>terminals
      list(term~>name term~>direction if(term~>net then term~>net~>name else nil))) 'ampLess)
    sort(foreach(mapcar net cv~>nets net~>name) 'alphalessp)))
procedure(ampBaseline(cv)
  let((matches inst effective property parameter value record)
    matches=setof(obj cv~>instances obj~>name=="PM0")
    ampRequire(length(matches)==1)
    inst=car(matches)
    ampRequire(and(inst~>libName=="gpdk090" inst~>cellName=="pmos1v" inst~>viewName=="symbol"
      equal(ampLinks(inst~>instTerms)
        list(list("B" "VDD") list("D" "net33") list("G" "Vbiasp") list("S" "VDD")))))
    effective=cdfGetInstCDF(inst)
    ampRequire(effective)
    foreach(record list(list("w" "20u") list("fw" "20u") list("l" "1u")
                        list("as" "5.6p") list("ad" "5.6p") list("ps" "40.56u") list("pd" "40.56u"))
      property=dbFindProp(inst car(record))
      parameter=cdfFindParamByName(effective car(record))
      ampRequire(and(property property~>valueType=="string" property~>value==cadr(record)
                     parameter parameter~>value==cadr(record))))
    foreach(record list(list("m" "1") list("fingers" "1") list("model" "gpdk090_pmos1v"))
      parameter=cdfFindParamByName(effective car(record))
      value=if(parameter && numberp(parameter~>value) then sprintf(nil "%.12g" parameter~>value)
                                                       else if(parameter then parameter~>value else nil))
      ampRequire(and(!dbFindProp(inst car(record)) value==cadr(record))))
    ampRequire(and(!dbFindProp(inst "nf") !cdfFindParamByName(effective "nf")))
    parameter=cdfFindParamByName(effective "dfm")
    ampRequire(and(!dbFindProp(inst "dfm") parameter parameter~>value=="Minimum"))))

procedure(ampPlain(value depth)
  ampRequire(depth<=8)
  cond(((null(value) || stringp(value) || numberp(value) || symbolp(value)) value)
       (listp(value)
        ampRequire(length(value)<=512)
        foreach(mapcar item value ampPlain(item depth+1)))
       (t error("C1_AMP_UNSUPPORTED_PROPERTY_VALUE"))))
procedure(ampPropRows(owner)
  ampRequire(length(owner~>prop)<=128)
  sort(foreach(mapcar prop owner~>prop
    list(prop~>name prop~>valueType ampPlain(prop~>value 0))) 'ampLess))
procedure(ampRef(ref)
  let((kind inst shapeMatches)
    if(!ref then nil else
      kind=ref~>objType
      cond(
        (kind=="net" list(kind ref~>name))
        (kind=="term" list(kind ref~>name ref~>direction if(ref~>net then ref~>net~>name else nil)))
        (kind=="inst" list(kind ref~>name ref~>libName ref~>cellName ref~>viewName))
        (kind=="instTerm" list(kind ref~>inst~>name ref~>name if(ref~>net then ref~>net~>name else nil)))
        (kind=="pin" list(kind ref~>name ref~>term~>name if(ref~>net then ref~>net~>name else nil)))
        (kind=="cellView" list(kind ref~>libName ref~>cellName ref~>viewName))
        (member(kind list("line" "ellipse" "label"))
          shapeMatches=setof(fig ref~>cellView~>shapes
            and(fig~>objType==kind equal(fig~>bBox ref~>bBox) equal(fig~>lpp ref~>lpp)))
          ampRequire(length(shapeMatches)==1)
          list(kind ampPlain(ref~>bBox 0) ampPlain(ref~>lpp 0)))
        (t error("AUTO120_UNSUPPORTED_REFERENCE_%L" kind))))))

procedure(ampShape(shape)
  let((kind geometry)
    kind=shape~>objType
    geometry=cond(
      (kind=="ellipse" ampPlain(shape~>bBox 0))
      (kind=="line" list(ampPlain(shape~>points 0) shape~>nPoints))
      (kind=="label" list(shape~>theLabel ampPlain(shape~>xy 0) shape~>height shape~>orient shape~>justify
        shape~>font shape~>isDrafted shape~>isOverbar shape~>isVisible shape~>labelType shape~>hasTextDisplay))
      (kind=="textDisplay" list(ampRef(shape~>owner) ampRef(shape~>associate) shape~>assocType
        shape~>text ampPlain(shape~>xy 0) shape~>height shape~>orient shape~>justify shape~>font
        shape~>isDrafted shape~>isOverbar shape~>isVisible shape~>isNameVisible shape~>isValueVisible))
      (t error("AUTO120_UNSUPPORTED_SHAPE_%L" kind)))
    list(kind shape~>layerName shape~>purpose ampPlain(shape~>bBox 0)
      geometry ampRef(shape~>net) ampRef(shape~>pin) ampRef(shape~>parent) ampPropRows(shape))))

; Each nested list is encoded recursively so log pretty-printer limits cannot
; discard values. Length-prefix every item to distinguish nesting and strings.
procedure(ampEncode(value depth)
  let((encoded item text)
    ampRequire(depth<=32)
    cond(
      (null(value) "N")
      (listp(value)
        ampRequire(length(value)<=1024)
        encoded=sprintf(nil "L%d:" length(value))
        foreach(memberValue value
          item=ampEncode(memberValue depth+1)
          encoded=strcat(encoded sprintf(nil "%d:" strlen(item)) item))
        encoded)
      (fixp(value) sprintf(nil "I%d" value))
      (floatp(value) sprintf(nil "D%.17g" value))
      (stringp(value) strcat("S" value))
      (symbolp(value) sprintf(nil "Y%L" value))
      (t error("AUTO120_UNSUPPORTED_SCALAR")))))

procedure(ampViewSignature(cv omitWidth)
  ampRequire(length(cv~>shapes)==158)
  foreach(row list(list("ellipse" 25) list("line" 118) list("label" 6) list("textDisplay" 9))
    ampRequire(length(setof(figure cv~>shapes figure~>objType==car(row)))==cadr(row)))
  list(ampSignature(cv omitWidth) ampPropRows(cv)
    sort(foreach(mapcar shape cv~>shapes ampEncode(ampShape(shape) 0)) 'alphalessp)))

procedure(ampTarget(lib mode)
  let((cv)
    cv=dbOpenCellViewByType(lib "Differential_Amplifier_TB2" "schematic" "" mode)
    ampRequire(and(cv cv~>libName==lib cv~>cellName=="Differential_Amplifier_TB2"
                   cv~>viewName=="schematic"))
    cv))
procedure(ampExactFinal(cv stage)
  let((matches inst cdf parameter value)
    matches=setof(item cv~>instances item~>name=="PM0")
    ampRequire(length(matches)==1)
    inst=car(matches)
    ampRequire(and(inst~>libName=="gpdk090" inst~>cellName=="pmos1v" inst~>viewName=="symbol"
       equal(ampLinks(inst~>instTerms)
        list(list("B" "VDD") list("D" "net33") list("G" "Vbiasp") list("S" "VDD")))))
    cdf=cdfGetInstCDF(inst)
    ampRequire(cdf)
    foreach(row list(list("w" "120n") list("fw" "120n") list("as" "69.6f") list("ad" "69.6f") list("ps" "1.16u") list("pd" "1.16u"))
      parameter=cdfFindParamByName(cdf car(row))
      ampRequire(and(!dbFindProp(inst car(row)) parameter parameter~>value==cadr(row)))
      printf("C1_AMP_AUTO_PROP|%s|%s|ABSENT|%s\n" stage car(row) parameter~>value))
    foreach(row list(list("m" "1") list("fingers" "1") list("model" "gpdk090_pmos1v")
                     list("dfm" "Minimum"))
      parameter=cdfFindParamByName(cdf car(row))
      value=if(parameter && numberp(parameter~>value) then sprintf(nil "%.12g" parameter~>value)
                                                    else if(parameter then parameter~>value else nil))
      ampRequire(and(!dbFindProp(inst car(row)) value==cadr(row))))
    parameter=cdfFindParamByName(cdf "l")
    value=dbFindProp(inst "l")
    ampRequire(and(value value~>valueType=="string" value~>value=="1u" parameter parameter~>value=="1u"))
    ampRequire(and(!dbFindProp(inst "nf") !cdfFindParamByName(cdf "nf")))
    printf("C1_AMP_AUTO_FIXED|%s|L=1u|DFM=Minimum|M=1|FINGERS=1|NF=ABSENT\n" stage)))

procedure(ampFrameToken(value)
  cond((null(value) "-")
       (stringp(value) if(strlen(value)<=64 then value else "UNSUPPORTED"))
       (numberp(value) sprintf(nil "%.12g" value))
       (t "UNSUPPORTED")))

procedure(ampReportFields(cv stage)
  let((device cf oa param)
    device=car(setof(item cv~>instances item~>name=="PM0"))
    cf=cdfGetInstCDF(device)
    foreach(row list(list("w" "120n") list("fw" "120n") list("as" "69.6f") list("ad" "69.6f")
        list("ps" "1.16u") list("pd" "1.16u") list("l" "1u") list("m" "1") list("fingers" "1")
        list("model" "gpdk090_pmos1v") list("dfm" "Minimum") list("nf" "-"))
      oa=dbFindProp(device car(row))
      param=if(cf then cdfFindParamByName(cf car(row)) else nil)
      printf("AUTO120_DIAG_PROP|%s|%s|%s|%L|%s|%s|%L|%L|%s\n" stage car(row) cadr(row)
        if(oa then t else nil) ampFrameToken(if(oa then oa~>valueType else nil))
        ampFrameToken(if(oa then oa~>value else nil)) if(param then t else nil)
        if(param then type(param~>value) else nil) ampFrameToken(if(param then param~>value else nil))))
    drain(poport)))
procedure(ampRecord(path value)
  let((port bytes)
    bytes=ampEncode(value 0)
    ampRequire(strlen(bytes)<131072)
    port=outfile(path)
    ampRequire(port)
    fprintf(port "%s\n" bytes)
    ampRequire(close(port))))
procedure(ampMatchFile(path sig)
  let((disk memory line other)
    disk=infile(path)
    ampRequire(disk)
    memory=instring(strcat(ampEncode(sig 0) "\n"))
    while(gets(line memory) ampRequire(and(gets(other disk) equal(line other))))
    ampRequire(!gets(other disk))
    close(memory)
    close(disk)))
; AMP_EDIT_ONLY
procedure(clkTokens(line sep)
  parseString(line strcat(sep "\r\n")))
procedure(clkUptime()
  let((p line v)
    p=infile("/proc/uptime")
    ampRequire(and(p gets(line p)))
    close(p)
    v=car(clkTokens(line " "))
    ampRequire(rexMatchp("^[0-9]+[.][0-9][0-9]$" v))
    atof(v)))
procedure(clkEpoch(s)
  let((hit n)
    hit=setof(row clkMap cadr(row)==s)
    ampRequire(length(hit)==1)
    n=atoi(caar(hit))
    ampRequire(and(stringToTime(s)==n equal(parseString(timeToString(n) " ") parseString(s " "))))
    n))
procedure(clkNow(label)
  let((u0 u1 stamp n)
    u0=clkUptime()
    stamp=getCurrentTime()
    u1=clkUptime()
    n=clkEpoch(stamp)
    ampRequire(and(u0>=clkPrevU u1>=u0 n>=clkPrevS
        n+1.0>clkWall+u0-clkU1-0.01 n<clkWall+u1-clkU0+0.01))
    clkPrevU=u1
    clkPrevS=n
    printf("C1_CLOCK|%s|%s|%d|%L|%L\n" label stamp n u0 u1)
    n))
procedure(clkStart()
  let((p line a rows statParts pid startToken startText foundPid foundDir utc sec frac match first)
    p=infile("@STAGE@/work/clock.rows")
    ampRequire(and(p gets(line p) equal(clkTokens(line "|") list("@OP@" "edit"))))
    ampRequire(gets(line p))
    clkLower=atoi(line)
    ampRequire(gets(line p))
    a=clkTokens(line "|")
    ampRequire(length(a)==3)
    clkWall=atof(car(a))
    clkU0=atof(cadr(a))
    clkU1=atof(caddr(a))
    clkPrevU=clkU1
    clkPrevS=clkLower-1
    clkMap=nil
    while(gets(line p)
      a=clkTokens(line "|")
      ampRequire(length(a)==3)
      clkMap=cons(a clkMap))
    close(p)
    ampRequire(length(clkMap)==47)
    p=infile("/proc/self/stat")
    ampRequire(and(p gets(line p)))
    close(p)
    pid=car(clkTokens(line " "))
    a=clkTokens(line ")")
    ampRequire(length(a)==2)
    statParts=clkTokens(cadr(a) " ")
    startToken=nth(19 statParts)
    ampRequire(and(startToken rexMatchp("^[0-9]+$" startToken)))
    p=infile("@STAGE@/work/cadence.log")
    ampRequire(p)
    rows=0
    while(gets(line p)
      rows=rows+1
      ampRequire(rows<=256)
      a=clkTokens(line " \t")
      when(and(length(a)==7 cadr(a)=="Program" caddr(a)=="start" nth(4 a)=="UTC")
        ampRequire(!startText)
        startText=strcat(nth(5 a) " " nth(6 a)))
      when(and(length(a)==4 cadr(a)=="Process" caddr(a)=="Id:")
        ampRequire(and(!foundPid nth(3 a)==pid)) foundPid=t)
      when(and(length(a)==4 cadr(a)=="Working" caddr(a)=="Directory:")
        ampRequire(and(!foundDir nth(3 a)=="cadence:@JOB@")) foundDir=t))
    close(p)
    ampRequire(and(startText foundPid foundDir))
    frac=substring(startText strlen(startText)-2 3)
    ampRequire(and(rexMatchp("^[0-9][0-9][0-9]$" frac) substring(startText strlen(startText)-3 1)=="."))
    utc=substring(startText 1 strlen(startText)-4)
    match=setof(row clkMap caddr(row)==utc)
    ampRequire(length(match)==1)
    sec=atoi(caar(match))
    ampRequire(sec+1>=clkLower)
    clkLower=max(clkLower if(atoi(frac)>0 then sec+1 else sec))
    first=clkNow("BEFORE_OPEN")
    ampRequire(first>=sec)
    printf("C1_PROCESS|%s|%s|%s|%d\n" pid startToken startText clkLower)
    drain(poport)))

procedure(ampSaveCounter(before after live)
  let((pre post old new conn)
    pre=cadr(before)
    post=cadr(after)
    old=assoc("schGeometryLastUpdated" pre)
    new=assoc("schGeometryLastUpdated" post)
    conn=assoc("connectivityLastUpdated" post)
    ampRequire(and(old new conn cadr(old)=="int" cadr(new)=="int"
      fixp(caddr(old)) fixp(caddr(new)) fixp(live) caddr(old)<live
      caddr(new)==live cadr(conn)=="int" caddr(conn)==live
      equal(car(before) car(after)) equal(caddr(before) caddr(after))
      equal(foreach(mapcar row pre if(car(row)=="schGeometryLastUpdated" then new else row)) post)))
    printf("AMP_SAVE_COUNTER|%d\n" live)
    drain(poport)))

procedure(ampStageProps(stage rows)
  let((seen)
    ampRequire(strlen(ampEncode(rows 0))<=4096)
    printf("C1_ROWS|%s|%s\n" stage ampEncode(rows 0))
    drain(poport)
    foreach(row rows
      ampRequire(and(length(row)==3 stringp(car(row)) stringp(cadr(row)) !member(car(row) seen)))
      seen=cons(car(row) seen))
    ampRequire(length(rows)==8)))
procedure(ampPreserved(sig)
  list(car(sig) setof(row cadr(sig) !member(car(row) list("connectivityLastUpdated" "lastSchematicExtraction")))
       caddr(sig)))
procedure(ampChecked(cv stage pre baseline)
  let((start finish count0 count1 current0 current1 ret post conn0 conn1 stamp0 stamp1)
    ampStageProps(strcat(stage "_BEFORE") cadr(pre))
    count0=dbGetCellViewCounter(cv)
    current0=dbIsConnCurrent(cv)
    start=clkNow(strcat(stage "_PRE"))
    ret=schCheck(cv)
    finish=clkNow(strcat(stage "_POST"))
    count1=dbGetCellViewCounter(cv)
    current1=dbIsConnCurrent(cv)
    ampStageProps(strcat(stage "_AFTER") ampPropRows(cv))
    post=ampViewSignature(cv nil)
    printf("C1_CHECK|%s|%L|%s|%s|%L|%L|%L|%L\n" stage ret timeToString(start) timeToString(finish) count0 count1 current0 current1)
    drain(poport)
    ampRequire(and(equal(ret list(0 0)) equal(ampPreserved(pre) ampPreserved(post))))
    conn0=assoc("connectivityLastUpdated" cadr(pre))
    conn1=assoc("connectivityLastUpdated" cadr(post))
    stamp0=assoc("lastSchematicExtraction" cadr(pre))
    stamp1=assoc("lastSchematicExtraction" cadr(post))
    ampRequire(and(conn0 conn1 stamp0 stamp1 cadr(conn0)=="int" cadr(conn1)=="int"
      fixp(caddr(conn0)) fixp(caddr(conn1)) fixp(count0) fixp(count1)
      count1>=count0 caddr(conn1)>=caddr(conn0) caddr(conn1)==count1 equal(current1 t)
      cadr(stamp0)=="time" cadr(stamp1)=="time" stringp(caddr(stamp0)) stringp(caddr(stamp1))))
    when(baseline ampRequire(and(equal(current0 t) caddr(conn0)==count0)))
    ampRequire(and(compareTime(caddr(stamp1) caddr(stamp0))>=0
      clkEpoch(caddr(stamp1))>=clkLower clkEpoch(caddr(stamp1))<=finish))
    post))

ampOwned=nil
ampStage="ENTRY"
procedure(ampMark(stage) ampStage=stage printf("AUTO120_STAGE|%s\n" stage) drain(poport))
procedure(ampPhase()
  let((lib tech cv fixed inst property parameter effective port key raw checked frozen saved)
    ampRequire(and(ampEncode(2 0)=="I2" ampEncode(2.5 0)=="D2.5"))
    clkStart()
    ampMark("LIBRARY")
    lib=ddGetObj("@LIB@")
    ampRequire(and(lib lib~>readPath=="@OWNED@"))
    tech=ddGetObj("cdsDefTechLib")
    ampRequire(and(tech tech~>readPath=="@TECH@" techGetTechFile(tech)))

    ampRequire(techGetTechFile(lib)~>libName=="cdsDefTechLib")
    ampMark("OPEN")
    cv=ampTarget("@LIB@" "a")
    ampOwned=cv
    ampRequire(cv~>mode=="a")
    ampMark("QUALIFY")

    ampMark("BASELINE")
    ampBaseline(cv)
    raw=ampViewSignature(cv nil)
    ampMatchFile("@STAGE@/qualified-before.txt" raw)
    ampMark("BASELINE_SCHEMATIC_CHECK")
    checked=ampChecked(cv "BASE" raw t)
    ampBaseline(cv)
    fixed=ampViewSignature(cv t)
    ampRequire(equal(cadr(checked) cadr(fixed)))
    ampMark("REMOVE_SIX")
    inst=car(setof(item cv~>instances item~>name=="PM0"))
    foreach(key list("w" "fw" "as" "ad" "ps" "pd")
      ampRequire(dbFindProp(inst key))
      dbDeletePropByName(inst key)
      ampRequire(!dbFindProp(inst key)))
    ampReportFields(cv "AFTER_REMOVE")
    raw=ampViewSignature(cv nil)
    ampStageProps("REMOVED" cadr(raw))
    ampRequire(equal(raw fixed))
    ampMark("SCHEMATIC_CHECK")
    frozen=ampChecked(cv "EDIT" raw nil)
    ampMark("PRE_SAVE_EFFECTIVE_CDF")
    ampExactFinal(cv "BEFORE_SAVE")
    ampRequire(equal(ampPreserved(frozen) ampPreserved(fixed)))
    ampRecord("@STAGE@/pre-save.txt" frozen)
    ampMark("SAVE")
    ampRequire(dbSave(cv))
    saved=ampViewSignature(cv nil)
    ampStageProps("SAVED" cadr(saved))
    ampRequire(dbIsConnCurrent(cv))
    ampSaveCounter(frozen saved dbGetCellViewCounter(cv))
    ampExactFinal(cv "SAVED")
    ampRecord("@STAGE@/saved-full.txt" saved)
    ampMark("VALUES")
    inst=car(setof(item cv~>instances item~>name=="PM0"))
    effective=cdfGetInstCDF(inst)
    foreach(key list("w" "fw" "as" "ad" "ps" "pd" "l" "m" "fingers" "nf" "model" "dfm")
      property=dbFindProp(inst key)
      parameter=cdfFindParamByName(effective key)
      printf("AUTO120_PROP|%s|%s|%s|%s\n" key
        ampFrameToken(if(property then property~>valueType else nil))
        ampFrameToken(if(property then property~>value else nil))
        ampFrameToken(if(parameter then parameter~>value else nil))))
    foreach(term inst~>instTerms
      printf("AUTO120_TERM|%s|%s\n" term~>name term~>net~>name))
    printf("AUTO120_MASTER|%s|%s|%s|%s\n" inst~>name inst~>libName inst~>cellName inst~>viewName)
    ampMark("CLOSE")
    ampRequire(dbClose(cv))
    ampOwned=nil
    printf("AUTO120_DONE|@OP@|edit\n")
    t))
if(errset(ampPhase() t) then exit(0) else printf("AUTO120_FAIL|%s\n" ampStage) drain(poport) when(ampOwned errset(dbClose(ampOwned) t)) exit(1))
