procedure(ampMark(stage) printf("AUTO120_STAGE|%s\n" stage) drain(poport))
procedure(ampMatchText(path bytes)
  let((disk memory line other)
    disk=infile(path)
    ampRequire(disk)
    memory=instring(bytes)
    while(gets(line memory) ampRequire(and(gets(other disk) equal(line other))))
    ampRequire(!gets(other disk))
    close(memory)
    close(disk)))

procedure(ampMatchFile(path sig) ampMatchText(path strcat(ampEncode(sig 0) "\n")))
procedure(ampPhase()
  let((lib tech cv fixed inst property parameter effective port key frames frameBytes)
    ampRequire(and(ampEncode(2 0)=="I2" ampEncode(2.5 0)=="D2.5"))
    ampMark("LIBRARY")
    lib=ddGetObj("@LIB@")
    ampRequire(and(lib lib~>readPath=="@OWNED@"))
    tech=ddGetObj("cdsDefTechLib")
    ampRequire(and(tech tech~>readPath=="@TECH@" techGetTechFile(tech)))

    ampRequire(techGetTechFile(lib)~>libName=="cdsDefTechLib")
    ampMark("OPEN")
    cv=ampTarget("@LIB@" "r")
    ampMark("QUALIFY")
    ampRequire(cv~>mode=="r")
    ampExactFinal(cv "FRESH_PROCESS_REOPEN")
    ampRequire(dbIsConnCurrent(cv))
    fixed=ampViewSignature(cv nil)
    ampMatchFile("@STAGE@/expected-footprint.txt" fixed)
    inst=car(setof(item cv~>instances item~>name=="PM0"))
    effective=cdfGetInstCDF(inst)
    foreach(key list("w" "fw" "as" "ad" "ps" "pd" "l" "m" "fingers" "nf" "model" "dfm")
      property=dbFindProp(inst key)
      parameter=cdfFindParamByName(effective key)
      if(key=="nf" then ampRequire(!parameter) else ampRequire(and(parameter stringp(parameter~>value))))
      frames=cons(sprintf(nil "AUTO120_PROP|%s|%s|%s|%s" key
        ampFrameToken(if(property then property~>valueType else nil))
        ampFrameToken(if(property then property~>value else nil))
        ampFrameToken(if(parameter then parameter~>value else nil))) frames))
    foreach(term inst~>instTerms
      frames=cons(sprintf(nil "AUTO120_TERM|%s|%s" term~>name term~>net~>name) frames))
    frames=sort(cons(sprintf(nil "AUTO120_MASTER|%s|%s|%s|%s" inst~>name inst~>libName inst~>cellName inst~>viewName) frames) 'alphalessp)
    ampMark("CLOSE")
    ampRequire(dbClose(cv))
    frameBytes="READ_ONLY_CLOSED|@OP@|@SAVED_SIGNATURE@\n"
    foreach(row frames
      printf("%s\n" row)
      frameBytes=strcat(frameBytes row "\n"))
    ampMatchText("@STAGE@/expected-frame.txt" frameBytes)
    port=outfile("@STAGE@/fixed-footprint.txt")
    ampRequire(port)
    fprintf(port "%s\n" ampEncode(fixed 0))
    ampRequire(close(port))
    ampMatchFile("@STAGE@/fixed-footprint.txt" fixed)
    port=outfile("@STAGE@/readback.txt")
    ampRequire(port)
    fprintf(port "%s" frameBytes)
    ampRequire(close(port))
    ampMatchText("@STAGE@/readback.txt" frameBytes)
    printf("AUTO120_DONE|@OP@|reopen\n")
    drain(poport)
    t))

procedure(ampAdeCheck(ok) unless(ok error("C1_AMP_ADE_REJECTED")) ok)
procedure(ampAdeVars(session stage)
  let((vars names)
    vars=asiGetDesignVarList(session)
    ampAdeCheck(and(listp(vars) 0<length(vars) length(vars)<=32))
    foreach(row vars
      ampAdeCheck(and(listp(row) length(row)==2 stringp(car(row))
                        (stringp(cadr(row)) || numberp(cadr(row)))))
      ampAdeCheck(!member(car(row) names))
      names=cons(car(row) names)
      ampAdeCheck(rexMatchp("^[A-Za-z][A-Za-z0-9_-]*$" car(row)))
      printf("C1_AMP_ADE_VAR|%s|%L|%L\n" stage car(row) cadr(row)))
    ampAdeCheck(and(member("VBIASN" names) member("VBIASP" names)))
    vars))
procedure(ampAdeRoute(session)
  let((cv)
    cv=asiGetTopCellView(session)
    ampAdeCheck(and(cv cv~>libName=="@LIB@" cv~>cellName=="Differential_Amplifier_TB2" cv~>viewName=="schematic"))))
procedure(ampAdePhase()
  let((win session sevId before lib tf ana name)
    envSetVal("asimenv.startup" "projectDir" 'string "@STAGE@/project")
    envSetVal("asimenv.startup" "simulator" 'string "spectre")
    foreach(api '(sevStartSession asiLoadState asiGetDesignVarList asiGetAnalysisNameList
                  asiGetEnabledAnalysisList asiGetAnalysis asiGetAnalysisFieldVal sevQuit)
      ampAdeCheck(isCallable(api)))
    lib=ddGetObj("@LIB@")
    ampAdeCheck(and(lib lib~>readPath=="@OWNED@"))
    tf=techGetTechFile(lib)
    ampAdeCheck(and(tf tf~>libName=="cdsDefTechLib"))
    printf("C1_AMP_ADE_STAGE|START_SESSION\n")
    ampAdeCheck(sevStartSession(?lib "@LIB@" ?cell "Differential_Amplifier_TB2" ?view "schematic"))
    win=hiGetCurrentWindow()
    session=asiGetSession(win)
    sevId=sevSession(win)
    ampAdeCheck(and(session sevId))
    ampAdeRoute(session)
    printf("C1_AMP_ADE_STAGE|LOAD_PINNED_STATE\n")
    ampAdeCheck(asiLoadState(session ?name "state1" ?option 'dir ?stateDir "@STAGE@/state-root"
                           ?lib "@LIB@" ?cell "Differential_Amplifier_TB2" ?simulator "spectre"))
    ampAdeRoute(session)
    ampAdeCheck(asiSetDesignVarList(session list(list("VBIASN" "0.320") list("VBIASP" "0.702"))))
    before=ampAdeVars(session "JOB_FIXED")
    ampAdeCheck(and(length(before)==2 cadr(assoc("VBIASN" before))=="0.320"
                     cadr(assoc("VBIASP" before))=="0.702"))
    printf("C1_AMP_ADE_STAGE|SELECT_ANALYSIS\n")
    foreach(name asiGetAnalysisNameList(session)
      ampAdeCheck(asiDisableAnalysis(asiGetAnalysis(session name))))
    ana=asiGetAnalysis(session 'dc)
    ampAdeCheck(ana)
    ampAdeCheck(and(asiEnableAnalysis(ana) asiIsAnalysisEnabled(ana)))
    ampAdeCheck(length(asiGetEnabledAnalysisList(session))==1)
    printf("C1_AMP_ADE_STAGE|EMIT_NETLIST\n")
    ampAdeCheck(sevNetlistFile(sevId 'recreate))
    ampAdeCheck(asiLoadState(session ?name "state1" ?option 'dir ?stateDir "@STAGE@/state-root"
                           ?lib "@LIB@" ?cell "Differential_Amplifier_TB2" ?simulator "spectre"))
    ampAdeRoute(session)
    printf("C1_AMP_ADE_STAGE|CLOSE_SESSION\n")
    ampAdeCheck(sevQuit(sevId))
    printf("C1_AMP_ADE_COMPLETE|child-netlist|@OP@\n")
    t))
if(errset(ampPhase() t) then
     printf("C1_VERIFIED_INDEPENDENT_REOPEN\n")
     drain(poport)
     if(errset(ampAdePhase() t) then exit(0) else exit(1))
   else exit(1))
