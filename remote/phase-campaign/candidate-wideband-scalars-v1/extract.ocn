resultPath = "/home/buet/cds_work/.cadence_mcp/wp14-candidate-wideband-ac-v1/psf"
outputPath = "/home/buet/cds_work/.cadence_mcp/wp14-candidate-wideband-scalars-v1/scalars.txt"

let((port wave xVec yVec sample index signal freq length lastIndex)
  port = outfile(outputPath)
  unless(port exit(1))
  fprintf(port "MCP_AC_STAGE|file_open\n")
  unless(openResults(resultPath)
    fprintf(port "MCP_AC_BLOCK|open_results\n")
    close(port)
    exit(1)
  )
  fprintf(port "MCP_AC_STAGE|results_open\n")
  unless(selectResult('ac)
    fprintf(port "MCP_AC_BLOCK|select_ac\n")
    close(port)
    exit(1)
  )
  fprintf(port "MCP_AC_STAGE|ac_selected\n")
  foreach(signal list("Vop" "Vom" "Vp" "Vm")
    wave = getData(signal)
    unless(wave wave = getData(strcat("/" signal)))
    unless(wave && drIsWaveform(wave)
      fprintf(port "MCP_AC_BLOCK|wave|%s\n" signal)
      close(port)
      exit(1)
    )
    xVec = drGetWaveformXVec(wave)
    yVec = drGetWaveformYVec(wave)
    length = drVectorLength(xVec)
    fprintf(port "MCP_AC_VECTOR|%s|%d|%d\n" signal length drVectorLength(yVec))
    unless(length >= 2 && length <= 1024 && equal(length drVectorLength(yVec))
      fprintf(port "MCP_AC_BLOCK|vector|%s\n" signal)
      close(port)
      exit(1)
    )
    lastIndex = sub1(length)
    for(index 0 lastIndex
      freq = drGetElem(xVec index)
      sample = drGetElem(yVec index)
      fprintf(port "MCP_AC_POINT|%s|%d|%L|%L|%L\n"
        signal index freq real(sample) imag(sample))
    )
  )
  fprintf(port "MCP_AC_POINT_COMPLETE|true\n")
  close(port)
  exit(0)
)
