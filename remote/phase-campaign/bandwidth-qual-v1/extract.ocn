let((port wave xVec yVec sample index signal freq length)
  port = outfile("@JOB@/frame.txt")
  unless(port exit(1))
  fprintf(port "BEGIN\n")
  unless(openResults("@JOB@/psf") close(port) exit(1))
  unless(member('ac results()) || member("ac" results()) close(port) exit(1))
  unless(selectResult('ac) close(port) exit(1))
  foreach(signal list("Vop" "Vom" "Vp" "Vm")
    wave = getData(signal)
    unless(wave wave = getData(strcat("/" signal)))
    unless(wave && drIsWaveform(wave) close(port) exit(1))
    xVec = drGetWaveformXVec(wave)
    yVec = drGetWaveformYVec(wave)
    length = drVectorLength(xVec)
    unless(length == @COUNT@ && drVectorLength(yVec) == @COUNT@ close(port) exit(1))
    fprintf(port "VECTOR|%s|%d\n" signal length)
    for(index 0 sub1(length)
      freq = drGetElem(xVec index)
      sample = drGetElem(yVec index)
      fprintf(port "POINT|%d|%L|%L|%L\n" index freq real(sample) imag(sample))
    )
  )
  fprintf(port "END\n")
  close(port)
  exit(0)
)
