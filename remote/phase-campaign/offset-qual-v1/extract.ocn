procedure(mcpOffsetScalar(name)
  let((data vec)
    data=getData(name)
    unless(data data=getData(strcat("/" name)))
    cond((numberp(data) data)
      (drIsWaveform(data)
        vec=drGetWaveformYVec(data)
        if(equal(drVectorLength(vec) 1) then drGetElem(vec 0) else nil))
      (t nil))))
let((port value)
  port=outfile("@JOB@/frame.txt")
  unless(port exit(1))
  unless(openResults("@PSF@") close(port) exit(1))
  unless(selectResult('dcOp) close(port) exit(1))
  fprintf(port "BEGIN\n")
  foreach(signal list("Vop" "Vom" "Vp" "Vm" "VDD")
    value=mcpOffsetScalar(signal)
    unless(numberp(value) close(port) exit(1))
    fprintf(port "%s|%.16g\n" signal value))
  fprintf(port "END\n")
  close(port))
exit(0)
