procedure(mcpScalar(name)
  let((data vec)
    data=getData(name)
    cond((numberp(data) data)
      (drIsWaveform(data)
        vec=drGetWaveformYVec(data)
        if(equal(drVectorLength(vec) 1) then drGetElem(vec 0) else nil))
      (t nil))))
let((port voltage current)
  port=outfile("@JOB@/frame.txt")
  unless(port exit(1))
  unless(openResults("@JOB@/psf") close(port) exit(1))
  unless(selectResult('dcOp) close(port) exit(1))
  fprintf(port "BEGIN\n")
  fprintf(port "NODE|Vop|%.16g\n" mcpScalar("Vop"))
  fprintf(port "NODE|Vom|%.16g\n" mcpScalar("Vom"))
  fprintf(port "NODE|Vp|%.16g\n" mcpScalar("Vp"))
  fprintf(port "NODE|Vm|%.16g\n" mcpScalar("Vm"))
  fprintf(port "NODE|VDD|%.16g\n" mcpScalar("VDD"))
  fprintf(port "NODE|Vbiasn|%.16g\n" mcpScalar("Vbiasn"))
  fprintf(port "NODE|Vbiasp|%.16g\n" mcpScalar("Vbiasp"))
  fprintf(port "SOURCE|vdd|%.16g|%.16g\n" mcpScalar("VDD") mcpScalar("V0:p"))
  fprintf(port "SOURCE|vss|%.16g|%.16g\n" mcpScalar("VSS") mcpScalar("V5:p"))
  fprintf(port "SOURCE|bias-n|%.16g|%.16g\n" mcpScalar("Vbiasn") mcpScalar("V3:p"))
  fprintf(port "SOURCE|bias-p|%.16g|%.16g\n" mcpScalar("Vbiasp") mcpScalar("V4:p"))
  fprintf(port "SOURCE|input-p|%.16g|%.16g\n" mcpScalar("Vp") mcpScalar("V1:p"))
  fprintf(port "SOURCE|input-m|%.16g|%.16g\n" mcpScalar("Vm") mcpScalar("V2:p"))
  fprintf(port "END\n")
  close(port))
exit(0)
