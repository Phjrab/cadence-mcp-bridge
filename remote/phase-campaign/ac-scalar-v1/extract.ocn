; Read only the existing candidate AC PSF at two fixed frequency points.
resultPath = "/home/buet/cds_work/.cadence_mcp/wp14-candidate-ac-v1/psf"
outputPath = "/home/buet/cds_work/.cadence_mcp/wp14-ac-scalars-v1/scalars.txt"

let((port wave xVec yVec sample index signal freq)
  port = outfile(outputPath)
  unless(port exit(1))
  unless(openResults(resultPath) close(port) exit(1))
  unless(selectResult('ac) close(port) exit(1))
  foreach(signal list("Vop" "Vom" "Vp" "Vm")
    wave = getData(signal)
    unless(wave wave = getData(strcat("/" signal)))
    unless(wave && drIsWaveform(wave) close(port) exit(1))
    xVec = drGetWaveformXVec(wave)
    yVec = drGetWaveformYVec(wave)
    unless(equal(drVectorLength(xVec) 2) && equal(drVectorLength(yVec) 2)
      close(port)
      exit(1)
    )
    for(index 0 1
      freq = drGetElem(xVec index)
      sample = drGetElem(yVec index)
      fprintf(port "MCP_AC_POINT|%s|%d|%L|%L|%L\n"
        signal index freq real(sample) imag(sample))
    )
  )
  fprintf(port "MCP_AC_POINT_COMPLETE|true\n")
  close(port)
  exit(0)
)
