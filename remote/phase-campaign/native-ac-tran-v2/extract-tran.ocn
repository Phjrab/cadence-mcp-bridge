let((port proof wave xVec yVec sample index signal time count)
  port=outfile("@JOB@/scalars.txt")
  unless(port exit(1))
  fprintf(port "MCP_TRAN_BEGIN\n")
  unless(openResults("@JOB@/psf") close(port) exit(1))
  unless(member('tran results()) || member("tran" results()) close(port) exit(1))
  unless(selectResult('tran) close(port) exit(1))
  proof=outfile("@JOB@/selector.txt")
  unless(proof close(port) exit(1))
  fprintf(proof "MCP_NATIVE_SELECTOR|tran\n") close(proof)
  foreach(signal list("Vop" "Vom" "Vp" "Vm" "VDD")
    wave=getData(signal)
    unless(wave wave=getData(strcat("/" signal)))
    unless(wave && drIsWaveform(wave) close(port) exit(1))
    xVec=drGetWaveformXVec(wave) yVec=drGetWaveformYVec(wave)
    count=drVectorLength(xVec)
    unless(count >= 401 && count <= 3000 && count==drVectorLength(yVec) close(port) exit(1))
    fprintf(port "MCP_TRAN_VECTOR|%s|%d|%d\n" signal count drVectorLength(yVec))
    for(index 0 sub1(count)
      time=drGetElem(xVec index) sample=drGetElem(yVec index)
      fprintf(port "MCP_TRAN_POINT|%s|%d|%.16g|%.16g\n" signal index time sample)))
  fprintf(port "MCP_TRAN_COMPLETE\n")
  close(port) exit(0))
