; Read six fixed ideal voltage sources in one preserved native DC result.
procedure(mcpPowerScalar(name)
  let((data vec)
    data=getData(name)
    cond((numberp(data) data)
      (drIsWaveform(data)
        vec=drGetWaveformYVec(data)
        if(equal(drVectorLength(vec) 1) then drGetElem(vec 0) else nil))
      (t nil))))
let((port current voltage)
  port=outfile("@FRAME@")
  unless(port exit(1))
  unless(openResults("@PSF@") close(port) exit(1))
  unless(selectResult('dcOp) close(port) exit(1))
  fprintf(port "BEGIN\n")
@READS@
  fprintf(port "END\n")
  close(port))
exit(0)
