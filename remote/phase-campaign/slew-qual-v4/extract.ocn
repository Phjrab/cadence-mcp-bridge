let((port wave xVec yVec sample index signal time length)
  port = outfile("@JOB@/frame.txt")
  unless(port exit(1))
  fprintf(port "BEGIN\n")
  unless(openResults("@JOB@/psf") close(port) exit(1))
  unless(member('tran results()) || member("tran" results()) close(port) exit(1))
  unless(selectResult('tran) close(port) exit(1))
  foreach(signal list("Vop" "Vom" "Vp" "Vm" "VDD")
    wave = getData(signal)
    unless(wave wave = getData(strcat("/" signal)))
    unless(wave && drIsWaveform(wave) close(port) exit(1))
    xVec = drGetWaveformXVec(wave)
    yVec = drGetWaveformYVec(wave)
    length = drVectorLength(xVec)
    unless(length >= 1001 && length <= 160000 && drVectorLength(yVec) == length close(port) exit(1))
    fprintf(port "VECTOR|%s|%d\n" signal length)
    for(index 0 sub1(length)
      time = drGetElem(xVec index)
      sample = drGetElem(yVec index)
      fprintf(port "POINT|%d|%.16g|%.16g\n" index time sample)
    )
  )
  fprintf(port "END\n")
  close(port)
  exit(0)
)
