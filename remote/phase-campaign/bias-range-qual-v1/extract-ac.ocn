resultPath = "@JOB@/psf"
outputPath = "@JOB@/scalars.txt"

let((port wave xVec yVec sample index signal freq length lastIndex)
  port = outfile(outputPath)
  unless(port exit(1))
  fprintf(port "MCP_AC_STAGE|file_open\n")
  unless(openResults(resultPath)
    close(port) exit(1))
  fprintf(port "MCP_AC_STAGE|results_open\n")
  unless(member('ac results()) || member("ac" results()) close(port) exit(1))
  unless(selectResult('ac)
    close(port) exit(1))
  let((proof) proof=outfile("@JOB@/selector.txt")
    unless(proof close(port) exit(1))
    fprintf(proof "MCP_NATIVE_SELECTOR|ac\n") close(proof))
  fprintf(port "MCP_AC_STAGE|ac_selected\n")
  foreach(signal list("Vop" "Vom" "Vp" "Vm")
    wave = getData(signal)
    unless(wave wave = getData(strcat("/" signal)))
    unless(wave && drIsWaveform(wave)
      close(port) exit(1))
    xVec = drGetWaveformXVec(wave)
    yVec = drGetWaveformYVec(wave)
    length = drVectorLength(xVec)
    fprintf(port "MCP_AC_VECTOR|%s|%d|%d\n" signal length drVectorLength(yVec))
    unless(length >= 70 && length <= 72 && equal(length drVectorLength(yVec))
      close(port) exit(1))
    lastIndex = sub1(length)
    for(index 0 lastIndex
      freq = drGetElem(xVec index)
      sample = drGetElem(yVec index)
      fprintf(port "MCP_AC_POINT|%s|%d|%L|%L|%L\n"
        signal index freq real(sample) imag(sample))
    )
  )
  fprintf(port "MCP_AC_POINT_COMPLETE|true\n")
  close(port)
  exit(0)
)
