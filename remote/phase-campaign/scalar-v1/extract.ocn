; Read two existing copied-netlist DC PSFs. No netlist, simulation, or OA write.
resultRoot = "/home/buet/cds_work/.cadence_mcp/wp14-copied-dc-v1"
outputPath = "/home/buet/cds_work/.cadence_mcp/wp14-dc-scalars-v1/scalars.txt"

procedure(mcpDcScalar(name)
  let((data vec)
    data = getData(name)
    unless(data data = getData(strcat("/" name)))
    cond(
      (numberp(data) data)
      (drIsWaveform(data)
        vec = drGetWaveformYVec(data)
        if(equal(drVectorLength(vec) 1) then drGetElem(vec 0) else nil)
      )
      (t nil)
    )
  )
)

let((port path vop vom vdd vp vm)
  port = outfile(outputPath)
  unless(port exit(1))
  foreach(mode list("baseline" "candidate")
    path = strcat(resultRoot "/" mode "/psf")
    unless(openResults(path) close(port) exit(1))
    unless(selectResult('dc) close(port) exit(1))
    vop = mcpDcScalar("Vop")
    vom = mcpDcScalar("Vom")
    vdd = mcpDcScalar("VDD")
    vp = mcpDcScalar("Vp")
    vm = mcpDcScalar("Vm")
    unless(numberp(vop) && numberp(vom) && numberp(vdd) &&
      numberp(vp) && numberp(vm)
      close(port)
      exit(1)
    )
    fprintf(port "MCP_DC_SCALAR|%s|Vop|%L\n" mode vop)
    fprintf(port "MCP_DC_SCALAR|%s|Vom|%L\n" mode vom)
    fprintf(port "MCP_DC_SCALAR|%s|VDD|%L\n" mode vdd)
    fprintf(port "MCP_DC_SCALAR|%s|Vp|%L\n" mode vp)
    fprintf(port "MCP_DC_SCALAR|%s|Vm|%L\n" mode vm)
  )
  fprintf(port "MCP_DC_SCALAR_COMPLETE|true\n")
  close(port)
  exit(0)
)
